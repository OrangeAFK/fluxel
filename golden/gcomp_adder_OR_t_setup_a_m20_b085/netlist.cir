* Fluxel JoSIM export
.param bias_mul=0.85

* Back-annotated simulation file written by InductEx v.6.1.52 on 2022/08/09.
* Author: L. Schindler
* Version: 3.0
* Last modification date: 4 August 2022
* Last modification by: T. Hall

* Copyright (c) 2018-2022 Lieze Schindler, Tessa Hall, Stellenbosch University

* Permission is hereby granted, free of charge, to any person obtaining a copy
* of this cell library and associated documentation files (the "Library"), to deal
* in the Library without restriction, including without limitation the rights
* to use, copy, modify, merge, publish, distribute, sublicense, and/or sell
* copies of the Library, and to permit persons to whom the Library is
* furnished to do so, subject to the following conditions:

* The above copyright notice and this permission notice shall be included in all
* copies or substantial portions of the Library.

* THE LIBRARY IS PROVIDED "AS IS", WITHOUT WARRANTY OF ANY KIND, EXPRESS OR
* IMPLIED, INCLUDING BUT NOT LIMITED TO THE WARRANTIES OF MERCHANTABILITY,
* FITNESS FOR A PARTICULAR PURPOSE AND NONINFRINGEMENT. IN NO EVENT SHALL THE
* AUTHORS OR COPYRIGHT HOLDERS BE LIABLE FOR ANY CLAIM, DAMAGES OR OTHER
* LIABILITY, WHETHER IN AN ACTION OF CONTRACT, TORT OR OTHERWISE, ARISING FROM,
* OUT OF OR IN CONNECTION WITH THE LIBRARY OR THE USE OR OTHER DEALINGS IN THE
* LIBRARY.

* For questions about the library, contact Tessa Hall, 19775539@sun.ac.za.

* The cell is not designed to be connected directly to passive transmission lines.

*$Ports 	a	b	clk	q
.subckt THmitll_AND2 a b clk q
.model jjmit jj(rtype=1, vg=2.8mV, cap=0.07pF, r0=160, rn=16, icrit=0.1mA)
.param Phi0=2.067833848E-15
.param B0=1
.param Ic0=0.0001
.param IcRs=100u*6.859904418
.param B0Rs=IcRs/Ic0*B0
.param Rsheet=2
.param Lsheet=1.13e-12
.param LP=0.5p
.param IC=2.5
.param LB=2p
.param BiasCoef=0.7*bias_mul

.param B1=2.5
.param B2=1.60
.param B3=1.94
.param B4=1.57
.param B5=1.25
.param B6=1.25
.param B7=2.5
.param B8=1.60
.param B9=1.94
.param B10=1.57
.param B11=1.25
.param B12=1.25
.param B13=2.5
.param B14=1.71
.param B15=2.5

.param IB1=(175u)*bias_mul
.param IB2=(162u)*bias_mul
.param IB3=(175u)*bias_mul
.param IB4=(162u)*bias_mul
.param IB5=(175u)*bias_mul
.param IB6=(124u)*bias_mul
.param IB7=(175u)*bias_mul

.param LB1=LB
.param LB2=LB
.param LB3=LB
.param LB4=LB
.param LB5=LB
.param LB6=LB
.param LB7=LB

.param L1=1.8843p
.param L2=4.2266p
.param L3=9.6820p
.param L4=0.9913p
.param L5=2.5745p
.param L6=1.8843p
.param L7=4.2266p
.param L8=9.6820p
.param L9=0.9913p
.param L10=2.5745p
.param L11=1.5293p
.param L12=2.6230p
.param L13=0.7965p
.param L14=0.7671p
.param L15=1.2144p

.param LP1=LP
.param LP3=LP
.param LP4=LP
.param LP7=LP
.param LP9=LP
.param LP10=LP
.param LP13=LP
.param LP14=LP
.param LP15=LP

.param RB1=B0Rs/B1
.param RB2=B0Rs/B2
.param RB3=B0Rs/B3
.param RB4=B0Rs/B4
.param RB5=B0Rs/B5
.param RB6=B0Rs/B6
.param RB7=B0Rs/B7
.param RB8=B0Rs/B8
.param RB9=B0Rs/B9
.param RB10=B0Rs/B10
.param RB11=B0Rs/B11
.param RB12=B0Rs/B12
.param RB13=B0Rs/B13
.param RB14=B0Rs/B14
.param RB15=B0Rs/B15

.param LRB1=(RB1/Rsheet)*Lsheet+LP
.param LRB2=(RB2/Rsheet)*Lsheet
.param LRB3=(RB3/Rsheet)*Lsheet+LP
.param LRB4=(RB4/Rsheet)*Lsheet+LP
.param LRB5=(RB5/Rsheet)*Lsheet
.param LRB6=(RB6/Rsheet)*Lsheet
.param LRB7=(RB7/Rsheet)*Lsheet+LP
.param LRB8=(RB8/Rsheet)*Lsheet
.param LRB9=(RB9/Rsheet)*Lsheet+LP
.param LRB10=(RB10/Rsheet)*Lsheet+LP
.param LRB11=(RB11/Rsheet)*Lsheet
.param LRB12=(RB12/Rsheet)*Lsheet
.param LRB13=(RB13/Rsheet)*Lsheet+LP
.param LRB14=(RB14/Rsheet)*Lsheet+LP
.param LRB15=(RB15/Rsheet)*Lsheet+LP

B1 1 2 jjmit  area=B1
B2 4 5 jjmit  area=B2
B3 5 6 jjmit  area=B3
B4 8 9 jjmit  area=B4
B5 8 10 jjmit  area=B5
B6 12 13 jjmit  area=B6
B7 14 15 jjmit  area=B7
B8 17 18 jjmit  area=B8
B9 18 19 jjmit  area=B9
B10 21 22 jjmit  area=B10
B11 21 23 jjmit  area=B11
B12 24 13 jjmit  area=B12
B13 25 26 jjmit  area=B13
B14 28 29 jjmit  area=B14
B15 31 32 jjmit  area=B15

IB1 0 3 pwl(0 0 5p IB1)
IB2 0 7 pwl(0 0 5p IB2)
IB3 0 16 pwl(0 0 5p IB3)
IB4 0 20 pwl(0 0 5p IB4)
IB5 0 27 pwl(0 0 5p IB5)
IB6 0 30 pwl(0 0 5p IB6)
IB7 0 33 pwl(0 0 5p IB7)

LB1 3 1 1.032E-012
LB2 7 5 3.135E-012
LB3 16 14 1.016E-012
LB4 20 18 3.19E-012
LB5 27 25 1.708E-012
LB6 30 28 6.363E-013
LB7 33 31 7.55E-013

L1 a 1 1.874E-012
L2 1 4 4.249E-012
L3 5 8 9.672E-012
L4 10 11 9.976E-013
L5 8 12 2.561E-012
L6 b 14 1.875E-012
L7 14 17 4.233E-012
L8 18 21 9.691E-012
L9 11 23 9.928E-013
L10 21 24 2.556E-012
L11 clk 25 1.531E-012
L12 25 28 2.626E-012
L13 28 11 7.973E-013
L14 13 31 7.691E-013
L15 31 q 1.217E-012

LP1 2 0 3.464E-013
LP3 6 0 6.827E-013
LP4 0 9 4.723E-013
LP7 15 0 3.484E-013
LP9 19 0 6.81E-013
LP10 22 0 4.756E-013
LP13 26 0 3.392E-013
LP14 29 0 3.972E-013
LP15 32 0 3.699E-013

RB1 1 101 RB1
LRB1 101 0 LRB1
RB2 4 104 RB2
LRB2 104 5 LRB2
RB3 5 105 RB3
LRB3 105 0 LRB3
RB4 108 8 RB4
LRB4 0 108 LRB4
RB5 8 110 RB5
LRB5 110 10 LRB5
RB6 12 112 RB6
LRB6 112 13 LRB6
RB7 14 114 RB7
LRB7 114 0 LRB7
RB8 17 117 RB8
LRB8 117 18 LRB8
RB9 18 118 RB9
LRB9 118 0 LRB9
RB10 21 121 RB10
LRB10 121 0 LRB10
RB11 123 21 RB11
LRB11 23 123 LRB11
RB12 24 124 RB12
LRB12 124 13 LRB12
RB13 25 125 RB13
LRB13 125 0 LRB13
RB14 28 128 RB14
LRB14 128 0 LRB14
RB15 31 131 RB15
LRB15 131 0 LRB15

.ends

* Back-annotated simulation file written by InductEx v.6.1.52 on 2022/07/25.
* Author: L. Schindler
* Version: 3.0
* Last modification date: 21 July 2022
* Last modification by: T. Hall

* Copyright (c) 2018-2022 Lieze Schindler, Tessa Hall, Stellenbosch University

* Permission is hereby granted, free of charge, to any person obtaining a copy
* of this cell library and associated documentation files (the "Library"), to deal
* in the Library without restriction, including without limitation the rights
* to use, copy, modify, merge, publish, distribute, sublicense, and/or sell
* copies of the Library, and to permit persons to whom the Library is
* furnished to do so, subject to the following conditions:

* The above copyright notice and this permission notice shall be included in all
* copies or substantial portions of the Library.

* THE LIBRARY IS PROVIDED "AS IS", WITHOUT WARRANTY OF ANY KIND, EXPRESS OR
* IMPLIED, INCLUDING BUT NOT LIMITED TO THE WARRANTIES OF MERCHANTABILITY,
* FITNESS FOR A PARTICULAR PURPOSE AND NONINFRINGEMENT. IN NO EVENT SHALL THE
* AUTHORS OR COPYRIGHT HOLDERS BE LIABLE FOR ANY CLAIM, DAMAGES OR OTHER
* LIABILITY, WHETHER IN AN ACTION OF CONTRACT, TORT OR OTHERWISE, ARISING FROM,
* OUT OF OR IN CONNECTION WITH THE LIBRARY OR THE USE OR OTHER DEALINGS IN THE
* LIBRARY.

* For questions about the library, contact Tessa Hall, 19775539@sun.ac.za.

* The cell is not designed to be connected directly to passive transmission lines.

*$Ports 	a	q
.subckt THmitll_DCSFQ a q
.model jjmit jj(rtype=1, vg=2.8mV, cap=0.07pF, r0=160, rn=16, icrit=0.1mA)
.param Phi0=2.067833848E-15
.param B0=1
.param Ic0=0.0001
.param IcRs=100u*6.859904418
.param B0Rs=IcRs/Ic0*B0
.param Rsheet=2
.param Lsheet=1.13e-12
.param LP=0.5p
.param IC=2.5
.param LB=2p
.param BiasCoef=0.7*bias_mul

.param B1=2.25
.param B2=2.25
.param B3=IC

.param IB1=(275u)*bias_mul
.param IB2=B3*Ic0*BiasCoef

.param LB1=LB
.param LB2=LB

.param L1=1p
.param L2=3.9p
.param L3=0.6p
.param L4=1.1p
.param L5=4.5p
.param L6=Phi0/(4*IC*Ic0)

.param LP2=LP
.param LP3=LP

.param RB1=B0Rs/B1
.param RB2=B0Rs/B2
.param RB3=B0Rs/B3

.param LRB1=(RB1/Rsheet)*Lsheet
.param LRB2=(RB2/Rsheet)*Lsheet+LP
.param LRB3=(RB3/Rsheet)*Lsheet+LP

B1 2 3 jjmit  area=B1
B2 5 6 jjmit  area=B2
B3 7 8 jjmit  area=B3

IB1 0 4 pwl(0 0 5p IB1)
IB2 0 9 pwl(0 0 5p IB2)

LB1 4 3 2.825E-012
LB2 9 7 2.942E-012

L1 a 1 1.672E-012
L2 1 0 3.901E-012
L3 1 2 5.953E-013
L4 3 5 1.1E-012
L5 5 7 4.542E-012
L6 7 q 2.012E-012

LP2 6 0 3.924E-013
LP3 8 0 3.841E-013

RB1 2 102 RB1
LRB1 102 3 LRB1
RB2 5 105 RB2
LRB2 105 0 LRB2
RB3 7 107 RB3
LRB3 107 0 LRB3

.ends

* Back-annotated simulation file written by InductEx v.6.1.52 on 2022/08/02.
* Author: L. Schindler
* Version: 3.0
* Last modification date: 1 August 2022
* Last modification by: T. Hall

* Copyright (c) 2018-2022 Lieze Schindler, Tessa Hall, Stellenbosch University

* Permission is hereby granted, free of charge, to any person obtaining a copy
* of this cell library and associated documentation files (the "Library"), to deal
* in the Library without restriction, including without limitation the rights
* to use, copy, modify, merge, publish, distribute, sublicense, and/or sell
* copies of the Library, and to permit persons to whom the Library is
* furnished to do so, subject to the following conditions:

* The above copyright notice and this permission notice shall be included in all
* copies or substantial portions of the Library.

* THE LIBRARY IS PROVIDED "AS IS", WITHOUT WARRANTY OF ANY KIND, EXPRESS OR
* IMPLIED, INCLUDING BUT NOT LIMITED TO THE WARRANTIES OF MERCHANTABILITY,
* FITNESS FOR A PARTICULAR PURPOSE AND NONINFRINGEMENT. IN NO EVENT SHALL THE
* AUTHORS OR COPYRIGHT HOLDERS BE LIABLE FOR ANY CLAIM, DAMAGES OR OTHER
* LIABILITY, WHETHER IN AN ACTION OF CONTRACT, TORT OR OTHERWISE, ARISING FROM,
* OUT OF OR IN CONNECTION WITH THE LIBRARY OR THE USE OR OTHER DEALINGS IN THE
* LIBRARY.

* For questions about the library, contact Tessa Hall, 19775539@sun.ac.za.

* The cell is not designed to be connected directly to passive transmission lines.

*$Ports 	a	clk	q
.subckt THmitll_DFF a clk q
.model jjmit jj(rtype=1, vg=2.8mV, cap=0.07pF, r0=160, rn=16, icrit=0.1mA)
.param Phi0=2.067833848E-15
.param B0=1
.param Ic0=0.0001
.param IcRs=100u*6.859904418
.param B0Rs=IcRs/Ic0*B0
.param Rsheet=2
.param Lsheet=1.13e-12
.param LP=0.5p
.param IC=2.5
.param LB=2p
.param BiasCoef=0.7*bias_mul

.param B1=2.5
.param B2=1.67
.param B3=2.32
.param B4=2.02
.param B5=2.5
.param B6=1.69
.param B7=2.5

.param IB1=(175u)*bias_mul
.param IB2=(222u)*bias_mul
.param IB3=(175u)*bias_mul
.param IB4=(175u)*bias_mul

.param LB1=LB
.param LB2=LB
.param LB3=LB
.param LB4=LB

.param L1=1.9553p
.param L2=3.8899p
.param L3=8.6023p
.param L4=2.0461p
.param L5=3.8124p
.param L6=4.6626p
.param L7=1.8248p

.param LP1=LP
.param LP3=LP
.param LP4=LP
.param LP5=LP
.param LP7=LP

.param RB1=B0Rs/B1
.param RB2=B0Rs/B2
.param RB3=B0Rs/B3
.param RB4=B0Rs/B4
.param RB5=B0Rs/B5
.param RB6=B0Rs/B6
.param RB7=B0Rs/B7

.param LRB1=(RB1/Rsheet)*Lsheet+LP
.param LRB2=(RB2/Rsheet)*Lsheet
.param LRB3=(RB3/Rsheet)*Lsheet+LP
.param LRB4=(RB4/Rsheet)*Lsheet+LP
.param LRB5=(RB5/Rsheet)*Lsheet+LP
.param LRB6=(RB6/Rsheet)*Lsheet
.param LRB7=(RB7/Rsheet)*Lsheet+LP

B1 1 2 jjmit  area=B1
B2 4 5 jjmit  area=B2
B3 5 6 jjmit  area=B3
B4 8 9 jjmit  area=B4
B5 10 11 jjmit  area=B5
B6 13 8 jjmit  area=B6
B7 14 15 jjmit  area=B7

IB1 0 3 pwl(0 0 5p IB1)
IB2 0 7 pwl(0 0 5p IB2)
IB3 0 12 pwl(0 0 5p IB3)
IB4 0 16 pwl(0 0 5p IB4)

LB1 3 1 LB1
LB2 7 5 LB2
LB3 12 10 LB3
LB4 16 14 LB4

L1 a 1 1.948E-012
L2 1 4 3.879E-012
L3 5 8 8.641E-012
L4 clk 10 2.035E-012
L5 10 13 3.799E-012
L6 8 14 4.675E-012
L7 14 q 1.809E-012

LP1 2 0 3.511E-013
LP3 6 0 3.717E-013
LP4 9 0 4.668E-013
LP5 11 0 4.339E-013
LP7 15 0 4.147E-013

RB1 1 101 RB1
LRB1 101 0 LRB1
RB2 4 104 RB2
LRB2 104 5 LRB2
RB3 5 105 RB3
LRB3 105 0 LRB3
RB4 8 108 RB4
LRB4 108 0 LRB4
RB5 10 110 RB5
LRB5 110 0 LRB5
RB6 13 113 RB6
LRB6 113 8 LRB6
RB7 14 114 RB7
LRB7 114 0 LRB7

.ends

* Back-annotated simulation file written by InductEx v.6.1.52 on 2022/07/25.
* Author: L. Schindler
* Version: 3.0
* Last modification date: 21 July 2022
* Last modification by: T. Hall

* Copyright (c) 2018-2022 Lieze Schindler, Tessa Hall, Stellenbosch University

* Permission is hereby granted, free of charge, to any person obtaining a copy
* of this cell library and associated documentation files (the "Library"), to deal
* in the Library without restriction, including without limitation the rights
* to use, copy, modify, merge, publish, distribute, sublicense, and/or sell
* copies of the Library, and to permit persons to whom the Library is
* furnished to do so, subject to the following conditions:

* The above copyright notice and this permission notice shall be included in all
* copies or substantial portions of the Library.

* THE LIBRARY IS PROVIDED "AS IS", WITHOUT WARRANTY OF ANY KIND, EXPRESS OR
* IMPLIED, INCLUDING BUT NOT LIMITED TO THE WARRANTIES OF MERCHANTABILITY,
* FITNESS FOR A PARTICULAR PURPOSE AND NONINFRINGEMENT. IN NO EVENT SHALL THE
* AUTHORS OR COPYRIGHT HOLDERS BE LIABLE FOR ANY CLAIM, DAMAGES OR OTHER
* LIABILITY, WHETHER IN AN ACTION OF CONTRACT, TORT OR OTHERWISE, ARISING FROM,
* OUT OF OR IN CONNECTION WITH THE LIBRARY OR THE USE OR OTHER DEALINGS IN THE
* LIBRARY.

* For questions about the library, contact Tessa Hall, 19775539@sun.ac.za.

* The cell is not designed to be connected directly to passive transmission lines.

*$Ports 	a	q
.subckt THmitll_JTL a q
.model jjmit jj(rtype=1, vg=2.8mV, cap=0.07pF, r0=160, rn=16, icrit=0.1mA)
.param Phi0=2.067833848E-15
.param B0=1
.param Ic0=0.0001
.param IcRs=100u*6.859904418
.param B0Rs=IcRs/Ic0*B0
.param Rsheet=2
.param Lsheet=1.13e-12
.param LP=0.5p
.param IC=2.5
.param LB=2p
.param BiasCoef=0.7*bias_mul

.param B1=IC
.param B2=IC

.param IB1=(B1+B2)*Ic0*BiasCoef

.param LB1=LB

.param L1=Phi0/(4*B1*Ic0)
.param L2=Phi0/(4*B1*Ic0)
.param L3=Phi0/(4*B2*Ic0)
.param L4=Phi0/(4*B2*Ic0)

.param LP1=LP
.param LP2=LP

.param RB1=B0Rs/B1
.param RB2=B0Rs/B2

.param LRB1=(RB1/Rsheet)*Lsheet+LP
.param LRB2=(RB2/Rsheet)*Lsheet+LP

B1 1 2 jjmit  area=B1
B2 5 6 jjmit  area=B2

IB1 0 4 pwl(0 0 5p IB1)

LB1 4 3 2.336E-012

L1 a 1 2.07E-012
L2 1 3 2.088E-012
L3 3 5 2.082E-012
L4 5 q 2.072E-012

LP1 2 0 3.137E-013
LP2 6 0 3.123E-013

RB1 1 101 RB1
LRB1 101 0 LRB1
RB2 5 105 RB2
LRB2 105 0 LRB2

.ends

* Back-annotated simulation file written by InductEx v.6.1.52 on 2022/08/07.
* Author: L. Schindler
* Version: 3.0
* Last modification date: 4 August 2022
* Last modification by: T. Hall

* Copyright (c) 2018-2022 Lieze Schindler, Tessa Hall, Stellenbosch University

* Permission is hereby granted, free of charge, to any person obtaining a copy
* of this cell library and associated documentation files (the "Library"), to deal
* in the Library without restriction, including without limitation the rights
* to use, copy, modify, merge, publish, distribute, sublicense, and/or sell
* copies of the Library, and to permit persons to whom the Library is
* furnished to do so, subject to the following conditions:

* The above copyright notice and this permission notice shall be included in all
* copies or substantial portions of the Library.

* THE LIBRARY IS PROVIDED "AS IS", WITHOUT WARRANTY OF ANY KIND, EXPRESS OR
* IMPLIED, INCLUDING BUT NOT LIMITED TO THE WARRANTIES OF MERCHANTABILITY,
* FITNESS FOR A PARTICULAR PURPOSE AND NONINFRINGEMENT. IN NO EVENT SHALL THE
* AUTHORS OR COPYRIGHT HOLDERS BE LIABLE FOR ANY CLAIM, DAMAGES OR OTHER
* LIABILITY, WHETHER IN AN ACTION OF CONTRACT, TORT OR OTHERWISE, ARISING FROM,
* OUT OF OR IN CONNECTION WITH THE LIBRARY OR THE USE OR OTHER DEALINGS IN THE
* LIBRARY.

* For questions about the library, contact Tessa Hall, 19775539@sun.ac.za.

* The cell is not designed to be connected directly to passive transmission lines.

*$Ports 	a	b	clk	q
.subckt THmitll_OR2 a b clk q
.model jjmit jj(rtype=1, vg=2.8mV, cap=0.07pF, r0=160, rn=16, icrit=0.1mA)
.param Phi0=2.067833848E-15
.param B0=1
.param Ic0=0.0001
.param IcRs=100u*6.859904418
.param B0Rs=IcRs/Ic0*B0
.param Rsheet=2
.param Lsheet=1.13e-12
.param LP=0.5p
.param IC=2.5
.param LB=2p
.param BiasCoef=0.7*bias_mul

.param B1=2.5
.param B2=1.67
.param B3=1.48
.param B4=2.5
.param B5=1.67
.param B6=1.48
.param B7=2.27
.param B8=2.36
.param B9=1.76
.param B10=2.5
.param B11=1.44
.param B12=2.5

.param IB1=(175u)*bias_mul
.param IB2=(175u)*bias_mul
.param IB3=(283u)*bias_mul
.param IB4=(158u)*bias_mul
.param IB5=(175u)*bias_mul
.param IB6=(175u)*bias_mul

.param LB1=LB
.param LB2=LB
.param LB3=LB
.param LB4=LB
.param LB5=LB
.param LB6=LB

.param L1=1.6049p
.param L2=4.4173p
.param L3=0.7163p
.param L4=1.6049p
.param L5=4.4173p
.param L6=0.7163p
.param L7=3.2947p
.param L8=8.7190p
.param L9=2.1422p
.param L10=3.7843p
.param L11=3.9628p
.param L12=1.6906p

.param LP1=LP
.param LP2=LP
.param LP4=LP
.param LP5=LP
.param LP8=LP
.param LP9=LP
.param LP10=LP
.param LP12=LP

.param RB1=B0Rs/B1
.param RB2=B0Rs/B2
.param RB3=B0Rs/B3
.param RB4=B0Rs/B4
.param RB5=B0Rs/B5
.param RB6=B0Rs/B6
.param RB7=B0Rs/B7
.param RB8=B0Rs/B8
.param RB9=B0Rs/B9
.param RB10=B0Rs/B10
.param RB11=B0Rs/B11
.param RB12=B0Rs/B12

.param LRB1=(RB1/Rsheet)*Lsheet+LP
.param LRB2=(RB2/Rsheet)*Lsheet+LP
.param LRB3=(RB3/Rsheet)*Lsheet
.param LRB4=(RB4/Rsheet)*Lsheet+LP
.param LRB5=(RB5/Rsheet)*Lsheet+LP
.param LRB6=(RB6/Rsheet)*Lsheet
.param LRB7=(RB7/Rsheet)*Lsheet
.param LRB8=(RB8/Rsheet)*Lsheet+LP
.param LRB9=(RB9/Rsheet)*Lsheet+LP
.param LRB10=(RB10/Rsheet)*Lsheet+LP
.param LRB11=(RB11/Rsheet)*Lsheet
.param LRB12=(RB12/Rsheet)*Lsheet+LP

B1 1 2 jjmit  area=B1
B2 4 5 jjmit  area=B2
B3 4 6 jjmit  area=B3
B4 8 9 jjmit  area=B4
B5 11 12 jjmit  area=B5
B6 11 13 jjmit  area=B6
B7 15 16 jjmit  area=B7
B8 16 17 jjmit  area=B8
B9 19 20 jjmit  area=B9
B10 21 22 jjmit  area=B10
B11 24 19 jjmit  area=B11
B12 25 26 jjmit  area=B12

IB1 0 3 pwl(0 0 5p IB1)
IB2 0 10 pwl(0 0 5p IB2)
IB3 0 14 pwl(0 0 5p IB3)
IB4 0 18 pwl(0 0 5p IB4)
IB5 0 23 pwl(0 0 5p IB5)
IB6 0 27 pwl(0 0 5p IB6)

LB1 3 1 LB1
LB2 10 8 LB2
LB3 14 7 LB3
LB4 18 16 LB4
LB5 23 21 LB5
LB6 27 25 LB6

L1 a 1 1.592E-012
L2 1 4 4.395E-012
L3 6 7 7.134E-013
L4 b 8 1.61E-012
L5 8 11 4.378E-012
L6 13 7 7.212E-013
L7 7 15 3.29E-012
L8 16 19 8.747E-012
L9 clk 21 2.161E-012
L10 21 24 3.766E-012
L11 19 25 3.926E-012
L12 25 q 1.675E-012

LP1 2 0 4.683E-013
LP2 5 0 4.125E-013
LP4 9 0 3.472E-013
LP5 12 0 4.43E-013
LP8 17 0 4.666E-013
LP9 20 0 4.384E-013
LP10 22 0 3.63E-013
LP12 26 0 4.421E-013

RB1 1 101 RB1
LRB1 101 0 LRB1
RB2 4 104 RB2
LRB2 104 0 LRB2
RB3 4 106 RB3
LRB3 106 6 LRB3
RB4 8 108 RB4
LRB4 108 0 LRB4
RB5 11 111 RB5
LRB5 111 0 LRB5
RB6 11 113 RB6
LRB6 113 13 LRB6
RB7 15 115 RB7
LRB7 115 16 LRB7
RB8 16 116 RB8
LRB8 116 0 LRB8
RB9 19 119 RB9
LRB9 119 0 LRB9
RB10 21 121 RB10
LRB10 121 0 LRB10
RB11 24 124 RB11
LRB11 124 19 LRB11
RB12 25 125 RB12
LRB12 125 0 LRB12

.ends

* Back-annotated simulation file written by InductEx v.6.1.52 on 2022/08/08.
* Adapted from Fluxonics SDQDC_v5
* Author: L. Schindler
* Version: 3.0
* Last modification date: 4 August 2022
* Last modification by: T. Hall

* Copyright (c) 2018-2022 Lieze Schindler, Tessa Hall, Stellenbosch University

* Permission is hereby granted, free of charge, to any person obtaining a copy
* of this cell library and associated documentation files (the "Library"), to deal
* in the Library without restriction, including without limitation the rights
* to use, copy, modify, merge, publish, distribute, sublicense, and/or sell
* copies of the Library, and to permit persons to whom the Library is
* furnished to do so, subject to the following conditions:

* The above copyright notice and this permission notice shall be included in all
* copies or substantial portions of the Library.

* THE LIBRARY IS PROVIDED "AS IS", WITHOUT WARRANTY OF ANY KIND, EXPRESS OR
* IMPLIED, INCLUDING BUT NOT LIMITED TO THE WARRANTIES OF MERCHANTABILITY,
* FITNESS FOR A PARTICULAR PURPOSE AND NONINFRINGEMENT. IN NO EVENT SHALL THE
* AUTHORS OR COPYRIGHT HOLDERS BE LIABLE FOR ANY CLAIM, DAMAGES OR OTHER
* LIABILITY, WHETHER IN AN ACTION OF CONTRACT, TORT OR OTHERWISE, ARISING FROM,
* OUT OF OR IN CONNECTION WITH THE LIBRARY OR THE USE OR OTHER DEALINGS IN THE
* LIBRARY.

* For questions about the library, contact Tessa Hall, 19775539@sun.ac.za.

* The cell is not designed to be connected directly to passive transmission lines.

*$Ports 	a	q
.subckt THmitll_SFQDC a q
.model jjmit jj(rtype=1, vg=2.8mV, cap=0.07pF, r0=160, rn=16, icrit=0.1mA)
.param Phi0=2.067833848E-15
.param B0=1
.param Ic0=0.0001
.param IcRs=100u*6.859904418
.param B0Rs=IcRs/Ic0*B0
.param Rsheet=2
.param Lsheet=1.13e-12
.param LP=0.5p
.param IC=2.5
.param LB=2p
.param BiasCoef=0.7*bias_mul

.param B1=3.25
.param B2=1.50
.param B3=1.75
.param B4=2.00
.param B5=3.00
.param B6=1.50
.param B7=1.50
.param B8=2.00

.param IB1=(280u)*bias_mul
.param IB2=(150u)*bias_mul
.param IB3=(220u)*bias_mul
.param IB4=(80u)*bias_mul

.param LB1=LB
.param LB2=LB
.param LB3=LB
.param LB4=LB

.param L1=1.522p
.param L2=0.827p
.param L3=1.12884p
.param L4=5.94p
.param L5=1.11098p
.param L6=3.216p
.param L7=0.215p
.param L8=0.954p
.param L9=3.699p
.param L10=2.010p
.param L11=1.510p

.param LR1=0.91p
.param R1=0.375

.param LP1=LP
.param LP3=LP
.param LP5=LP
.param LP7=LP
.param LP8=LP

.param RB1=B0Rs/B1
.param RB2=B0Rs/B2
.param RB3=B0Rs/B3
.param RB4=B0Rs/B4
.param RB5=B0Rs/B5
.param RB6=B0Rs/B6
.param RB7=B0Rs/B7
.param RB8=B0Rs/B8

.param LRB1=(RB1/Rsheet)*Lsheet+LP
.param LRB2=(RB2/Rsheet)*Lsheet
.param LRB3=(RB3/Rsheet)*Lsheet+LP
.param LRB4=(RB4/Rsheet)*Lsheet
.param LRB5=(RB5/Rsheet)*Lsheet+LP
.param LRB6=(RB6/Rsheet)*Lsheet
.param LRB7=(RB7/Rsheet)*Lsheet+LP
.param LRB8=(RB8/Rsheet)*Lsheet+LP

B1 1 2 jjmit  area=B1
B2 5 6 jjmit  area=B2
B3 6 8 jjmit  area=B3
B4 10 11 jjmit  area=B4
B5 11 12 jjmit  area=B5
B6 14 15 jjmit  area=B6
B7 17 18 jjmit  area=B7
B8 21 22 jjmit  area=B8

IB1 0 3 pwl(0 0 5p IB1)
IB2 0 7 pwl(0 0 5p IB2)
IB3 0 16 pwl(0 0 5p IB3)
IB4 0 20 pwl(0 0 5p IB4)

LB1 3 1 1.401E-012
LB2 7 6 6.064E-013
LB3 16 15 1.989E-012
LB4 20 19 8.87E-013

L1 a 1 1.529E-012
L2 1 4 8.239E-013
L3 5 4 1.124E-012
L4 6 9 5.898E-012
L5 4 10 1.111E-012
L6 9 11 3.227E-012
L7 9 14 2.138E-013
L8 15 17 9.503E-013
L9 17 19 3.696E-012
L10 19 21 2.001E-012
L11 21 q 1.496E-012

R1 0 13 R1
LR1 13 9 9.11E-013

LP1 2 0 3.162E-013
LP3 8 0 4.507E-013
LP5 12 0 6.57E-013
LP7 18 0 4.343E-013
LP8 22 0 3.726E-013

RB1 1 101 RB1
LRB1 101 0 LRB1
RB2 5 105 RB2
LRB2 105 6 LRB2
RB3 6 106 RB3
LRB3 106 0 LRB3
RB4 10 110 RB4
LRB4 110 11 LRB4
RB5 11 111 RB5
LRB5 111 0 LRB5
RB6 14 114 RB6
LRB6 114 15 LRB6
RB7 17 117 RB7
LRB7 117 0 LRB7
RB8 21 121 RB8
LRB8 121 0 LRB8

.ends

* Back-annotated simulation file written by InductEx v.6.1.52 on 2022/07/25.
* Author: L. Schindler
* Version: 3.0
* Last modification date: 25 July 2022
* Last modification by: T. Hall

* Copyright (c) 2018-2022 Lieze Schindler, Tessa Hall, Stellenbosch University

* Permission is hereby granted, free of charge, to any person obtaining a copy
* of this cell library and associated documentation files (the "Library"), to deal
* in the Library without restriction, including without limitation the rights
* to use, copy, modify, merge, publish, distribute, sublicense, and/or sell
* copies of the Library, and to permit persons to whom the Library is
* furnished to do so, subject to the following conditions:

* The above copyright notice and this permission notice shall be included in all
* copies or substantial portions of the Library.

* THE LIBRARY IS PROVIDED "AS IS", WITHOUT WARRANTY OF ANY KIND, EXPRESS OR
* IMPLIED, INCLUDING BUT NOT LIMITED TO THE WARRANTIES OF MERCHANTABILITY,
* FITNESS FOR A PARTICULAR PURPOSE AND NONINFRINGEMENT. IN NO EVENT SHALL THE
* AUTHORS OR COPYRIGHT HOLDERS BE LIABLE FOR ANY CLAIM, DAMAGES OR OTHER
* LIABILITY, WHETHER IN AN ACTION OF CONTRACT, TORT OR OTHERWISE, ARISING FROM,
* OUT OF OR IN CONNECTION WITH THE LIBRARY OR THE USE OR OTHER DEALINGS IN THE
* LIBRARY.

* For questions about the library, contact Tessa Hall, 19775539@sun.ac.za.

* The cell is not designed to be connected directly to passive transmission lines.

*$Ports a	q0	q1
.subckt THmitll_SPLIT a q0 q1
.model jjmit jj(rtype=1, vg=2.8mV, cap=0.07pF, r0=160, rn=16, icrit=0.1mA)
.param Phi0=2.067833848E-15
.param B0=1
.param Ic0=0.0001
.param IcRs=100u*6.859904418
.param B0Rs=IcRs/Ic0*B0
.param Rsheet=2
.param Lsheet=1.13e-12
.param LP=0.5p
.param IC=2.5
.param LB=2p
.param BiasCoef=0.7*bias_mul

.param B1=IC
.param B2=IC
.param B3=IC

.param IB1=BiasCoef*Ic0*B1
.param IB2=BiasCoef*Ic0*B2
.param IB3=IB2

.param LB1=LB
.param LB2=LB
.param LB3=LB

.param L1=Phi0/(4*IC*Ic0)
.param L2=(Phi0/(2*B1*Ic0))/2
.param L3=L2
.param L4=Phi0/(4*IC*Ic0)
.param L5=L3
.param L6=L4

.param LP1=LP
.param LP2=LP
.param LP3=LP

.param RB1=B0Rs/B1
.param RB2=B0Rs/B2
.param RB3=B0Rs/B3

.param LRB1=(RB1/Rsheet)*Lsheet+LP
.param LRB2=(RB2/Rsheet)*Lsheet+LP
.param LRB3=(RB3/Rsheet)*Lsheet+LP

B1 1 2 jjmit  area=B1
B2 5 6 jjmit  area=B2
B3 8 9 jjmit  area=B3

IB1 0 3 pwl(0 0 5p IB1)
IB2 0 7 pwl(0 0 5p IB2)
IB3 0 10 pwl(0 0 5p IB3)

LB1 3 1 1.712E-012
LB2 7 5 2.279E-012
LB3 10 8 2.858E-012

L1 a 1 2.062E-012
L2 1 4 2.06E-012
L3 5 4 2.079E-012
L4 5 q0 2.081E-012
L5 4 8 2.076E-012
L6 8 q1 2.086E-012

LP1 2 0 4.263E-013
LP2 6 0 3.75E-013
LP3 9 0 4.312E-013

RB1 1 101 RB1
LRB1 101 0 LRB1
RB2 5 105 RB2
LRB2 105 0 LRB2
RB3 8 108 RB3
LRB3 108 0 LRB3

.ends

* Back-annotated simulation file written by InductEx v.6.1.52 on 2022/08/29.
* Author: L. Schindler
* Version: 3.0
* Last modification date: 28 August 2022
* Last modification by: T. Hall

* Copyright (c) 2018-2022 Lieze Schindler, Tessa Hall, Stellenbosch University

* Permission is hereby granted, free of charge, to any person obtaining a copy
* of this cell library and associated documentation files (the "Library"), to deal
* in the Library without restriction, including without limitation the rights
* to use, copy, modify, merge, publish, distribute, sublicense, and/or sell
* copies of the Library, and to permit persons to whom the Library is
* furnished to do so, subject to the following conditions:

* The above copyright notice and this permission notice shall be included in all
* copies or substantial portions of the Library.

* THE LIBRARY IS PROVIDED "AS IS", WITHOUT WARRANTY OF ANY KIND, EXPRESS OR
* IMPLIED, INCLUDING BUT NOT LIMITED TO THE WARRANTIES OF MERCHANTABILITY,
* FITNESS FOR A PARTICULAR PURPOSE AND NONINFRINGEMENT. IN NO EVENT SHALL THE
* AUTHORS OR COPYRIGHT HOLDERS BE LIABLE FOR ANY CLAIM, DAMAGES OR OTHER
* LIABILITY, WHETHER IN AN ACTION OF CONTRACT, TORT OR OTHERWISE, ARISING FROM,
* OUT OF OR IN CONNECTION WITH THE LIBRARY OR THE USE OR OTHER DEALINGS IN THE
* LIBRARY.

*For questions about the library, contact Tessa Hall, 19775539@sun.ac.za

*$Ports 	a	b	clk	q
.subckt THmitll_XOR a b clk q
.model jjmit jj(rtype=1, vg=2.8mV, cap=0.07pF, r0=160, rn=16, icrit=0.1mA)
.param Phi0=2.067833848E-15
.param B0=1
.param Ic0=0.0001
.param IcRs=100u*6.859904418
.param B0Rs=IcRs/Ic0*B0
.param Rsheet=2
.param Lsheet=1.13e-12
.param LP=0.5p
.param IC=2.5
.param LB=2p
.param BiasCoef=0.7*bias_mul

.param B1=2.5
.param B2=2.0
.param B3=2.02
.param B4=2.5
.param B5=2.0
.param B6=2.02
.param B7=1.96
.param B8=1.65
.param B9=2.5
.param B10=1.46
.param B11=2.5

.param IB1=(175u)*bias_mul
.param IB2=(175u)*bias_mul
.param IB3=(273u)*bias_mul
.param IB4=(175u)*bias_mul
.param IB5=(175u)*bias_mul

.param LB1=LB
.param LB2=LB
.param LB3=LB
.param LB4=LB
.param LB5=LB

.param L1=1.5740p
.param L2=3.1407p
.param L3=4.7381p
.param L4=1.5740p
.param L5=3.1407p
.param L6=4.7381p
.param L7=4.7751p
.param L8=1.1983p
.param L9=3.2191p
.param L10=3.7711p
.param L11=1.4703p

.param LP1=LP
.param LP2=LP
.param LP4=LP
.param LP5=LP
.param LP8=LP
.param LP9=LP
.param LP11=LP

.param RB1=B0Rs/B1
.param RB2=B0Rs/B2
.param RB3=B0Rs/B3
.param RB4=B0Rs/B4
.param RB5=B0Rs/B5
.param RB6=B0Rs/B6
.param RB7=B0Rs/B7
.param RB8=B0Rs/B8
.param RB9=B0Rs/B9
.param RB10=B0Rs/B10
.param RB11=B0Rs/B11

.param LRB1=(RB1/Rsheet)*Lsheet+LP
.param LRB2=(RB2/Rsheet)*Lsheet+LP
.param LRB3=(RB3/Rsheet)*Lsheet
.param LRB4=(RB4/Rsheet)*Lsheet+LP
.param LRB5=(RB5/Rsheet)*Lsheet+LP
.param LRB6=(RB6/Rsheet)*Lsheet
.param LRB7=(RB7/Rsheet)*Lsheet
.param LRB8=(RB8/Rsheet)*Lsheet+LP
.param LRB9=(RB9/Rsheet)*Lsheet+LP
.param LRB10=(RB10/Rsheet)*Lsheet
.param LRB11=(RB11/Rsheet)*Lsheet+LP

B1 1 2 jjmit  area=B1
B2 4 5 jjmit  area=B2
B3 4 6 jjmit  area=B3
B4 8 9 jjmit  area=B4
B5 11 12 jjmit  area=B5
B6 11 13 jjmit  area=B6
B7 7 15 jjmit  area=B7
B8 16 17 jjmit  area=B8
B9 18 19 jjmit  area=B9
B10 21 16 jjmit  area=B10
B11 22 23 jjmit  area=B11

IB1 0 3 pwl(0 0 5p IB1)
IB2 0 10 pwl(0 0 5p IB2)
IB3 0 14 pwl(0 0 5p IB3)
IB4 0 20 pwl(0 0 5p IB4)
IB5 0 24 pwl(0 0 5p IB5)

LB1 3 1 8.314E-013
LB2 10 8 9.179E-013
LB3 14 7 3.234E-012
LB4 20 18 1.047E-012
LB5 24 22 1.004E-012

L1 a 1 1.57E-012
L2 1 4 3.128E-012
L3 6 7 4.746E-012
L4 b 8 1.578E-012
L5 8 11 3.145E-012
L6 7 13 4.763E-012
L7 15 16 4.74E-012
L8 clk 18 1.196E-012
L9 18 21 3.224E-012
L10 16 22 3.775E-012
L11 22 q 1.459E-012

LP1 2 0 4.215E-013
LP2 5 0 4.657E-013
LP4 9 0 3.32E-013
LP5 12 0 3.87E-013
LP8 17 0 4.698E-013
LP9 19 0 3.611E-013
LP11 23 0 4.394E-013

RB1 1 101 RB1
LRB1 101 0 LRB1
RB2 4 104 RB2
LRB2 104 0 LRB2
RB3 4 106 RB3
LRB3 106 6 LRB3
RB4 8 108 RB4
LRB4 108 0 LRB4
RB5 11 111 RB5
LRB5 111 0 LRB5
RB6 11 113 RB6
LRB6 113 13 LRB6
RB7 7 115 RB7
LRB7 115 15 LRB7
RB8 16 116 RB8
LRB8 116 0 LRB8
RB9 18 118 RB9
LRB9 118 0 LRB9
RB10 21 121 RB10
LRB10 121 16 LRB10
RB11 22 122 RB11
LRB11 122 0 LRB11

.ends

Xand_ab THmitll_AND2 n_split_a_q1 n_split_b_q1 n_c3_q1 n_and_ab_q
Xand_cin THmitll_AND2 n_split_xor_q1 n_split_cin_q1 n_c5_q0 n_and_cin_q
Xc0 THmitll_SPLIT n_clk n_c0_q0 n_c0_q1
Xc1 THmitll_SPLIT n_c0_q0 n_c1_q0 n_c1_q1
Xc2 THmitll_SPLIT n_c0_q1 n_c2_q0 n_c2_q1
Xc3 THmitll_SPLIT n_c1_q0 n_c3_q0 n_c3_q1
Xc4 THmitll_SPLIT n_c1_q1 n_c4_q0 n_c4_q1
Xc5 THmitll_SPLIT n_c2_q0 n_c5_q0 n_c5_q1
Xc6 THmitll_SPLIT n_c2_q1 n_c6_q0 n_c6_q1
Xdff_and THmitll_DFF n_jtl_and_q n_c5_q1 n_dff_and_q
Xdff_cin THmitll_DFF n_cin n_c4_q0 n_dff_cin_q
Xdff_sum THmitll_DFF n_jtl_sum_q n_c6_q1 n_dff_sum_q
Xjtl_and THmitll_JTL n_and_ab_q n_jtl_and_q
Xjtl_sum THmitll_JTL n_xor_sum_q n_jtl_sum_q
Xor_cout THmitll_OR2 n_and_cin_q n_dff_and_q n_c6_q0 n_or_cout_q
Xsplit_a THmitll_SPLIT n_a n_split_a_q0 n_split_a_q1
Xsplit_b THmitll_SPLIT n_b n_split_b_q0 n_split_b_q1
Xsplit_cin THmitll_SPLIT n_dff_cin_q n_split_cin_q0 n_split_cin_q1
Xsplit_xor THmitll_SPLIT n_xor_ab_q n_split_xor_q0 n_split_xor_q1
Xxor_ab THmitll_XOR n_split_a_q0 n_split_b_q0 n_c3_q0 n_xor_ab_q
Xxor_sum THmitll_XOR n_split_xor_q0 n_split_cin_q0 n_c4_q1 n_xor_sum_q

Xfxsrc_a THmitll_DCSFQ n_fxsrc_a_a n_a
Ifxsrc_a 0 n_fxsrc_a_a pwl(0 0 220p 0 223p 600u 226p 0)
Xfxsrc_b THmitll_DCSFQ n_fxsrc_b_a n_b
Ifxsrc_b 0 n_fxsrc_b_a pwl(0 0)
Xfxsrc_cin THmitll_DCSFQ n_fxsrc_cin_a n_cin
Ifxsrc_cin 0 n_fxsrc_cin_a pwl(0 0)
Xfxsrc_clk THmitll_DCSFQ n_fxsrc_clk_a n_clk
Ifxsrc_clk 0 n_fxsrc_clk_a pwl(0 0 224.558p 0 227.558p 600u 230.558p 0)

Xfxload_cout THmitll_SFQDC n_or_cout_q n_fxload_cout_q
Rfxload_cout n_fxload_cout_q 0 2
Xfxload_sum THmitll_SFQDC n_dff_sum_q n_fxload_sum_q
Rfxload_sum n_fxload_sum_q 0 2

.tran 0.025p 724.558p 0
* fluxel-map and_ab.a P(B1|XAND_AB)
* fluxel-map and_ab.b P(B7|XAND_AB)
* fluxel-map and_ab.clk P(B13|XAND_AB)
* fluxel-map and_ab.q P(B15|XAND_AB)
* fluxel-map and_cin.a P(B1|XAND_CIN)
* fluxel-map and_cin.b P(B7|XAND_CIN)
* fluxel-map and_cin.clk P(B13|XAND_CIN)
* fluxel-map and_cin.q P(B15|XAND_CIN)
* fluxel-map c0.a P(B1|XC0)
* fluxel-map c0.q0 P(B2|XC0)
* fluxel-map c0.q1 P(B3|XC0)
* fluxel-map c1.a P(B1|XC1)
* fluxel-map c1.q0 P(B2|XC1)
* fluxel-map c1.q1 P(B3|XC1)
* fluxel-map c2.a P(B1|XC2)
* fluxel-map c2.q0 P(B2|XC2)
* fluxel-map c2.q1 P(B3|XC2)
* fluxel-map c3.a P(B1|XC3)
* fluxel-map c3.q0 P(B2|XC3)
* fluxel-map c3.q1 P(B3|XC3)
* fluxel-map c4.a P(B1|XC4)
* fluxel-map c4.q0 P(B2|XC4)
* fluxel-map c4.q1 P(B3|XC4)
* fluxel-map c5.a P(B1|XC5)
* fluxel-map c5.q0 P(B2|XC5)
* fluxel-map c5.q1 P(B3|XC5)
* fluxel-map c6.a P(B1|XC6)
* fluxel-map c6.q0 P(B2|XC6)
* fluxel-map c6.q1 P(B3|XC6)
* fluxel-map dff_and.a P(B1|XDFF_AND)
* fluxel-map dff_and.clk P(B5|XDFF_AND)
* fluxel-map dff_and.q P(B7|XDFF_AND)
* fluxel-map dff_cin.a P(B1|XDFF_CIN)
* fluxel-map dff_cin.clk P(B5|XDFF_CIN)
* fluxel-map dff_cin.q P(B7|XDFF_CIN)
* fluxel-map dff_sum.a P(B1|XDFF_SUM)
* fluxel-map dff_sum.clk P(B5|XDFF_SUM)
* fluxel-map dff_sum.q P(B7|XDFF_SUM)
* fluxel-map fxload_cout.a P(B1|XFXLOAD_COUT)
* fluxel-map fxload_cout.q P(B8|XFXLOAD_COUT)
* fluxel-map fxload_sum.a P(B1|XFXLOAD_SUM)
* fluxel-map fxload_sum.q P(B8|XFXLOAD_SUM)
* fluxel-map fxsrc_a.a P(B1|XFXSRC_A)
* fluxel-map fxsrc_a.q P(B3|XFXSRC_A)
* fluxel-map fxsrc_b.a P(B1|XFXSRC_B)
* fluxel-map fxsrc_b.q P(B3|XFXSRC_B)
* fluxel-map fxsrc_cin.a P(B1|XFXSRC_CIN)
* fluxel-map fxsrc_cin.q P(B3|XFXSRC_CIN)
* fluxel-map fxsrc_clk.a P(B1|XFXSRC_CLK)
* fluxel-map fxsrc_clk.q P(B3|XFXSRC_CLK)
* fluxel-map jtl_and.a P(B1|XJTL_AND)
* fluxel-map jtl_and.q P(B2|XJTL_AND)
* fluxel-map jtl_sum.a P(B1|XJTL_SUM)
* fluxel-map jtl_sum.q P(B2|XJTL_SUM)
* fluxel-map or_cout.a P(B1|XOR_COUT)
* fluxel-map or_cout.b P(B4|XOR_COUT)
* fluxel-map or_cout.clk P(B10|XOR_COUT)
* fluxel-map or_cout.q P(B12|XOR_COUT)
* fluxel-map split_a.a P(B1|XSPLIT_A)
* fluxel-map split_a.q0 P(B2|XSPLIT_A)
* fluxel-map split_a.q1 P(B3|XSPLIT_A)
* fluxel-map split_b.a P(B1|XSPLIT_B)
* fluxel-map split_b.q0 P(B2|XSPLIT_B)
* fluxel-map split_b.q1 P(B3|XSPLIT_B)
* fluxel-map split_cin.a P(B1|XSPLIT_CIN)
* fluxel-map split_cin.q0 P(B2|XSPLIT_CIN)
* fluxel-map split_cin.q1 P(B3|XSPLIT_CIN)
* fluxel-map split_xor.a P(B1|XSPLIT_XOR)
* fluxel-map split_xor.q0 P(B2|XSPLIT_XOR)
* fluxel-map split_xor.q1 P(B3|XSPLIT_XOR)
* fluxel-map xor_ab.a P(B1|XXOR_AB)
* fluxel-map xor_ab.b P(B4|XXOR_AB)
* fluxel-map xor_ab.clk P(B9|XXOR_AB)
* fluxel-map xor_ab.q P(B11|XXOR_AB)
* fluxel-map xor_sum.a P(B1|XXOR_SUM)
* fluxel-map xor_sum.b P(B4|XXOR_SUM)
* fluxel-map xor_sum.clk P(B9|XXOR_SUM)
* fluxel-map xor_sum.q P(B11|XXOR_SUM)
.print p(B1.Xand_ab) p(B7.Xand_ab) p(B13.Xand_ab) p(B15.Xand_ab) p(B1.Xand_cin) p(B7.Xand_cin) p(B13.Xand_cin) p(B15.Xand_cin) p(B1.Xc0) p(B2.Xc0) p(B3.Xc0) p(B1.Xc1) p(B2.Xc1) p(B3.Xc1) p(B1.Xc2) p(B2.Xc2) p(B3.Xc2) p(B1.Xc3) p(B2.Xc3) p(B3.Xc3) p(B1.Xc4) p(B2.Xc4) p(B3.Xc4) p(B1.Xc5) p(B2.Xc5) p(B3.Xc5) p(B1.Xc6) p(B2.Xc6) p(B3.Xc6) p(B1.Xdff_and) p(B5.Xdff_and) p(B7.Xdff_and) p(B1.Xdff_cin) p(B5.Xdff_cin) p(B7.Xdff_cin) p(B1.Xdff_sum) p(B5.Xdff_sum) p(B7.Xdff_sum) p(B1.Xfxload_cout) p(B8.Xfxload_cout) p(B1.Xfxload_sum) p(B8.Xfxload_sum) p(B1.Xfxsrc_a) p(B3.Xfxsrc_a) p(B1.Xfxsrc_b) p(B3.Xfxsrc_b) p(B1.Xfxsrc_cin) p(B3.Xfxsrc_cin) p(B1.Xfxsrc_clk) p(B3.Xfxsrc_clk) p(B1.Xjtl_and) p(B2.Xjtl_and) p(B1.Xjtl_sum) p(B2.Xjtl_sum) p(B1.Xor_cout) p(B4.Xor_cout) p(B10.Xor_cout) p(B12.Xor_cout) p(B1.Xsplit_a) p(B2.Xsplit_a) p(B3.Xsplit_a) p(B1.Xsplit_b) p(B2.Xsplit_b) p(B3.Xsplit_b) p(B1.Xsplit_cin) p(B2.Xsplit_cin) p(B3.Xsplit_cin) p(B1.Xsplit_xor) p(B2.Xsplit_xor) p(B3.Xsplit_xor) p(B1.Xxor_ab) p(B4.Xxor_ab) p(B9.Xxor_ab) p(B11.Xxor_ab) p(B1.Xxor_sum) p(B4.Xxor_sum) p(B9.Xxor_sum) p(B11.Xxor_sum)
.end
