* Fluxel JoSIM export
.param bias_mul=1

* Back-annotated simulation file written by InductEx v.6.1.52 on 2022/07/25.
* Author: L. Schindler
* Version: 3.0
* Last modification date: 21 July 2022
* Last modification by: T. Hall

* Copyright (c) 2018-2022 Lieze Schindler, Tessa Hall, Stellenbosch University

* Permission is hereby granted, free of charge, to any person obtaining a copy
* of this cell library and associated documentation files (the "Library"), to deal
* in the Library without restriction, including without limitation the rights
* to use, copy, modify, merge, publish, distribute, sublicense, and/or sell
* copies of the Library, and to permit persons to whom the Library is
* furnished to do so, subject to the following conditions:

* The above copyright notice and this permission notice shall be included in all
* copies or substantial portions of the Library.

* THE LIBRARY IS PROVIDED "AS IS", WITHOUT WARRANTY OF ANY KIND, EXPRESS OR
* IMPLIED, INCLUDING BUT NOT LIMITED TO THE WARRANTIES OF MERCHANTABILITY,
* FITNESS FOR A PARTICULAR PURPOSE AND NONINFRINGEMENT. IN NO EVENT SHALL THE
* AUTHORS OR COPYRIGHT HOLDERS BE LIABLE FOR ANY CLAIM, DAMAGES OR OTHER
* LIABILITY, WHETHER IN AN ACTION OF CONTRACT, TORT OR OTHERWISE, ARISING FROM,
* OUT OF OR IN CONNECTION WITH THE LIBRARY OR THE USE OR OTHER DEALINGS IN THE
* LIBRARY.

* For questions about the library, contact Tessa Hall, 19775539@sun.ac.za.

* The cell is not designed to be connected directly to passive transmission lines.

*$Ports 	a	q
.subckt THmitll_DCSFQ a q
.model jjmit jj(rtype=1, vg=2.8mV, cap=0.07pF, r0=160, rn=16, icrit=0.1mA)
.param Phi0=2.067833848E-15
.param B0=1
.param Ic0=0.0001
.param IcRs=100u*6.859904418
.param B0Rs=IcRs/Ic0*B0
.param Rsheet=2
.param Lsheet=1.13e-12
.param LP=0.5p
.param IC=2.5
.param LB=2p
.param BiasCoef=0.7*bias_mul

.param B1=2.25
.param B2=2.25
.param B3=IC

.param IB1=(275u)*bias_mul
.param IB2=B3*Ic0*BiasCoef

.param LB1=LB
.param LB2=LB

.param L1=1p
.param L2=3.9p
.param L3=0.6p
.param L4=1.1p
.param L5=4.5p
.param L6=Phi0/(4*IC*Ic0)

.param LP2=LP
.param LP3=LP

.param RB1=B0Rs/B1
.param RB2=B0Rs/B2
.param RB3=B0Rs/B3

.param LRB1=(RB1/Rsheet)*Lsheet
.param LRB2=(RB2/Rsheet)*Lsheet+LP
.param LRB3=(RB3/Rsheet)*Lsheet+LP

B1 2 3 jjmit  area=B1
B2 5 6 jjmit  area=B2
B3 7 8 jjmit  area=B3

IB1 0 4 pwl(0 0 5p IB1)
IB2 0 9 pwl(0 0 5p IB2)

LB1 4 3 2.825E-012
LB2 9 7 2.942E-012

L1 a 1 1.672E-012
L2 1 0 3.901E-012
L3 1 2 5.953E-013
L4 3 5 1.1E-012
L5 5 7 4.542E-012
L6 7 q 2.012E-012

LP2 6 0 3.924E-013
LP3 8 0 3.841E-013

RB1 2 102 RB1
LRB1 102 3 LRB1
RB2 5 105 RB2
LRB2 105 0 LRB2
RB3 7 107 RB3
LRB3 107 0 LRB3

.ends

* Back-annotated simulation file written by InductEx v.6.1.52 on 2022/08/02.
* Author: L. Schindler
* Version: 3.0
* Last modification date: 1 August 2022
* Last modification by: T. Hall

* Copyright (c) 2018-2022 Lieze Schindler, Tessa Hall, Stellenbosch University

* Permission is hereby granted, free of charge, to any person obtaining a copy
* of this cell library and associated documentation files (the "Library"), to deal
* in the Library without restriction, including without limitation the rights
* to use, copy, modify, merge, publish, distribute, sublicense, and/or sell
* copies of the Library, and to permit persons to whom the Library is
* furnished to do so, subject to the following conditions:

* The above copyright notice and this permission notice shall be included in all
* copies or substantial portions of the Library.

* THE LIBRARY IS PROVIDED "AS IS", WITHOUT WARRANTY OF ANY KIND, EXPRESS OR
* IMPLIED, INCLUDING BUT NOT LIMITED TO THE WARRANTIES OF MERCHANTABILITY,
* FITNESS FOR A PARTICULAR PURPOSE AND NONINFRINGEMENT. IN NO EVENT SHALL THE
* AUTHORS OR COPYRIGHT HOLDERS BE LIABLE FOR ANY CLAIM, DAMAGES OR OTHER
* LIABILITY, WHETHER IN AN ACTION OF CONTRACT, TORT OR OTHERWISE, ARISING FROM,
* OUT OF OR IN CONNECTION WITH THE LIBRARY OR THE USE OR OTHER DEALINGS IN THE
* LIBRARY.

* For questions about the library, contact Tessa Hall, 19775539@sun.ac.za.

* The cell is not designed to be connected directly to passive transmission lines.

*$Ports 	a	clk	q
.subckt THmitll_DFF a clk q
.model jjmit jj(rtype=1, vg=2.8mV, cap=0.07pF, r0=160, rn=16, icrit=0.1mA)
.param Phi0=2.067833848E-15
.param B0=1
.param Ic0=0.0001
.param IcRs=100u*6.859904418
.param B0Rs=IcRs/Ic0*B0
.param Rsheet=2
.param Lsheet=1.13e-12
.param LP=0.5p
.param IC=2.5
.param LB=2p
.param BiasCoef=0.7*bias_mul

.param B1=2.5
.param B2=1.67
.param B3=2.32
.param B4=2.02
.param B5=2.5
.param B6=1.69
.param B7=2.5

.param IB1=(175u)*bias_mul
.param IB2=(222u)*bias_mul
.param IB3=(175u)*bias_mul
.param IB4=(175u)*bias_mul

.param LB1=LB
.param LB2=LB
.param LB3=LB
.param LB4=LB

.param L1=1.9553p
.param L2=3.8899p
.param L3=8.6023p
.param L4=2.0461p
.param L5=3.8124p
.param L6=4.6626p
.param L7=1.8248p

.param LP1=LP
.param LP3=LP
.param LP4=LP
.param LP5=LP
.param LP7=LP

.param RB1=B0Rs/B1
.param RB2=B0Rs/B2
.param RB3=B0Rs/B3
.param RB4=B0Rs/B4
.param RB5=B0Rs/B5
.param RB6=B0Rs/B6
.param RB7=B0Rs/B7

.param LRB1=(RB1/Rsheet)*Lsheet+LP
.param LRB2=(RB2/Rsheet)*Lsheet
.param LRB3=(RB3/Rsheet)*Lsheet+LP
.param LRB4=(RB4/Rsheet)*Lsheet+LP
.param LRB5=(RB5/Rsheet)*Lsheet+LP
.param LRB6=(RB6/Rsheet)*Lsheet
.param LRB7=(RB7/Rsheet)*Lsheet+LP

B1 1 2 jjmit  area=B1
B2 4 5 jjmit  area=B2
B3 5 6 jjmit  area=B3
B4 8 9 jjmit  area=B4
B5 10 11 jjmit  area=B5
B6 13 8 jjmit  area=B6
B7 14 15 jjmit  area=B7

IB1 0 3 pwl(0 0 5p IB1)
IB2 0 7 pwl(0 0 5p IB2)
IB3 0 12 pwl(0 0 5p IB3)
IB4 0 16 pwl(0 0 5p IB4)

LB1 3 1 LB1
LB2 7 5 LB2
LB3 12 10 LB3
LB4 16 14 LB4

L1 a 1 1.948E-012
L2 1 4 3.879E-012
L3 5 8 8.641E-012
L4 clk 10 2.035E-012
L5 10 13 3.799E-012
L6 8 14 4.675E-012
L7 14 q 1.809E-012

LP1 2 0 3.511E-013
LP3 6 0 3.717E-013
LP4 9 0 4.668E-013
LP5 11 0 4.339E-013
LP7 15 0 4.147E-013

RB1 1 101 RB1
LRB1 101 0 LRB1
RB2 4 104 RB2
LRB2 104 5 LRB2
RB3 5 105 RB3
LRB3 105 0 LRB3
RB4 8 108 RB4
LRB4 108 0 LRB4
RB5 10 110 RB5
LRB5 110 0 LRB5
RB6 13 113 RB6
LRB6 113 8 LRB6
RB7 14 114 RB7
LRB7 114 0 LRB7

.ends

* Back-annotated simulation file written by InductEx v.6.1.52 on 2022/08/08.
* Adapted from Fluxonics SDQDC_v5
* Author: L. Schindler
* Version: 3.0
* Last modification date: 4 August 2022
* Last modification by: T. Hall

* Copyright (c) 2018-2022 Lieze Schindler, Tessa Hall, Stellenbosch University

* Permission is hereby granted, free of charge, to any person obtaining a copy
* of this cell library and associated documentation files (the "Library"), to deal
* in the Library without restriction, including without limitation the rights
* to use, copy, modify, merge, publish, distribute, sublicense, and/or sell
* copies of the Library, and to permit persons to whom the Library is
* furnished to do so, subject to the following conditions:

* The above copyright notice and this permission notice shall be included in all
* copies or substantial portions of the Library.

* THE LIBRARY IS PROVIDED "AS IS", WITHOUT WARRANTY OF ANY KIND, EXPRESS OR
* IMPLIED, INCLUDING BUT NOT LIMITED TO THE WARRANTIES OF MERCHANTABILITY,
* FITNESS FOR A PARTICULAR PURPOSE AND NONINFRINGEMENT. IN NO EVENT SHALL THE
* AUTHORS OR COPYRIGHT HOLDERS BE LIABLE FOR ANY CLAIM, DAMAGES OR OTHER
* LIABILITY, WHETHER IN AN ACTION OF CONTRACT, TORT OR OTHERWISE, ARISING FROM,
* OUT OF OR IN CONNECTION WITH THE LIBRARY OR THE USE OR OTHER DEALINGS IN THE
* LIBRARY.

* For questions about the library, contact Tessa Hall, 19775539@sun.ac.za.

* The cell is not designed to be connected directly to passive transmission lines.

*$Ports 	a	q
.subckt THmitll_SFQDC a q
.model jjmit jj(rtype=1, vg=2.8mV, cap=0.07pF, r0=160, rn=16, icrit=0.1mA)
.param Phi0=2.067833848E-15
.param B0=1
.param Ic0=0.0001
.param IcRs=100u*6.859904418
.param B0Rs=IcRs/Ic0*B0
.param Rsheet=2
.param Lsheet=1.13e-12
.param LP=0.5p
.param IC=2.5
.param LB=2p
.param BiasCoef=0.7*bias_mul

.param B1=3.25
.param B2=1.50
.param B3=1.75
.param B4=2.00
.param B5=3.00
.param B6=1.50
.param B7=1.50
.param B8=2.00

.param IB1=(280u)*bias_mul
.param IB2=(150u)*bias_mul
.param IB3=(220u)*bias_mul
.param IB4=(80u)*bias_mul

.param LB1=LB
.param LB2=LB
.param LB3=LB
.param LB4=LB

.param L1=1.522p
.param L2=0.827p
.param L3=1.12884p
.param L4=5.94p
.param L5=1.11098p
.param L6=3.216p
.param L7=0.215p
.param L8=0.954p
.param L9=3.699p
.param L10=2.010p
.param L11=1.510p

.param LR1=0.91p
.param R1=0.375

.param LP1=LP
.param LP3=LP
.param LP5=LP
.param LP7=LP
.param LP8=LP

.param RB1=B0Rs/B1
.param RB2=B0Rs/B2
.param RB3=B0Rs/B3
.param RB4=B0Rs/B4
.param RB5=B0Rs/B5
.param RB6=B0Rs/B6
.param RB7=B0Rs/B7
.param RB8=B0Rs/B8

.param LRB1=(RB1/Rsheet)*Lsheet+LP
.param LRB2=(RB2/Rsheet)*Lsheet
.param LRB3=(RB3/Rsheet)*Lsheet+LP
.param LRB4=(RB4/Rsheet)*Lsheet
.param LRB5=(RB5/Rsheet)*Lsheet+LP
.param LRB6=(RB6/Rsheet)*Lsheet
.param LRB7=(RB7/Rsheet)*Lsheet+LP
.param LRB8=(RB8/Rsheet)*Lsheet+LP

B1 1 2 jjmit  area=B1
B2 5 6 jjmit  area=B2
B3 6 8 jjmit  area=B3
B4 10 11 jjmit  area=B4
B5 11 12 jjmit  area=B5
B6 14 15 jjmit  area=B6
B7 17 18 jjmit  area=B7
B8 21 22 jjmit  area=B8

IB1 0 3 pwl(0 0 5p IB1)
IB2 0 7 pwl(0 0 5p IB2)
IB3 0 16 pwl(0 0 5p IB3)
IB4 0 20 pwl(0 0 5p IB4)

LB1 3 1 1.401E-012
LB2 7 6 6.064E-013
LB3 16 15 1.989E-012
LB4 20 19 8.87E-013

L1 a 1 1.529E-012
L2 1 4 8.239E-013
L3 5 4 1.124E-012
L4 6 9 5.898E-012
L5 4 10 1.111E-012
L6 9 11 3.227E-012
L7 9 14 2.138E-013
L8 15 17 9.503E-013
L9 17 19 3.696E-012
L10 19 21 2.001E-012
L11 21 q 1.496E-012

R1 0 13 R1
LR1 13 9 9.11E-013

LP1 2 0 3.162E-013
LP3 8 0 4.507E-013
LP5 12 0 6.57E-013
LP7 18 0 4.343E-013
LP8 22 0 3.726E-013

RB1 1 101 RB1
LRB1 101 0 LRB1
RB2 5 105 RB2
LRB2 105 6 LRB2
RB3 6 106 RB3
LRB3 106 0 LRB3
RB4 10 110 RB4
LRB4 110 11 LRB4
RB5 11 111 RB5
LRB5 111 0 LRB5
RB6 14 114 RB6
LRB6 114 15 LRB6
RB7 17 117 RB7
LRB7 117 0 LRB7
RB8 21 121 RB8
LRB8 121 0 LRB8

.ends

* Back-annotated simulation file written by InductEx v.6.1.52 on 2022/07/25.
* Author: L. Schindler
* Version: 3.0
* Last modification date: 25 July 2022
* Last modification by: T. Hall

* Copyright (c) 2018-2022 Lieze Schindler, Tessa Hall, Stellenbosch University

* Permission is hereby granted, free of charge, to any person obtaining a copy
* of this cell library and associated documentation files (the "Library"), to deal
* in the Library without restriction, including without limitation the rights
* to use, copy, modify, merge, publish, distribute, sublicense, and/or sell
* copies of the Library, and to permit persons to whom the Library is
* furnished to do so, subject to the following conditions:

* The above copyright notice and this permission notice shall be included in all
* copies or substantial portions of the Library.

* THE LIBRARY IS PROVIDED "AS IS", WITHOUT WARRANTY OF ANY KIND, EXPRESS OR
* IMPLIED, INCLUDING BUT NOT LIMITED TO THE WARRANTIES OF MERCHANTABILITY,
* FITNESS FOR A PARTICULAR PURPOSE AND NONINFRINGEMENT. IN NO EVENT SHALL THE
* AUTHORS OR COPYRIGHT HOLDERS BE LIABLE FOR ANY CLAIM, DAMAGES OR OTHER
* LIABILITY, WHETHER IN AN ACTION OF CONTRACT, TORT OR OTHERWISE, ARISING FROM,
* OUT OF OR IN CONNECTION WITH THE LIBRARY OR THE USE OR OTHER DEALINGS IN THE
* LIBRARY.

* For questions about the library, contact Tessa Hall, 19775539@sun.ac.za.

* The cell is not designed to be connected directly to passive transmission lines.

*$Ports a	q0	q1
.subckt THmitll_SPLIT a q0 q1
.model jjmit jj(rtype=1, vg=2.8mV, cap=0.07pF, r0=160, rn=16, icrit=0.1mA)
.param Phi0=2.067833848E-15
.param B0=1
.param Ic0=0.0001
.param IcRs=100u*6.859904418
.param B0Rs=IcRs/Ic0*B0
.param Rsheet=2
.param Lsheet=1.13e-12
.param LP=0.5p
.param IC=2.5
.param LB=2p
.param BiasCoef=0.7*bias_mul

.param B1=IC
.param B2=IC
.param B3=IC

.param IB1=BiasCoef*Ic0*B1
.param IB2=BiasCoef*Ic0*B2
.param IB3=IB2

.param LB1=LB
.param LB2=LB
.param LB3=LB

.param L1=Phi0/(4*IC*Ic0)
.param L2=(Phi0/(2*B1*Ic0))/2
.param L3=L2
.param L4=Phi0/(4*IC*Ic0)
.param L5=L3
.param L6=L4

.param LP1=LP
.param LP2=LP
.param LP3=LP

.param RB1=B0Rs/B1
.param RB2=B0Rs/B2
.param RB3=B0Rs/B3

.param LRB1=(RB1/Rsheet)*Lsheet+LP
.param LRB2=(RB2/Rsheet)*Lsheet+LP
.param LRB3=(RB3/Rsheet)*Lsheet+LP

B1 1 2 jjmit  area=B1
B2 5 6 jjmit  area=B2
B3 8 9 jjmit  area=B3

IB1 0 3 pwl(0 0 5p IB1)
IB2 0 7 pwl(0 0 5p IB2)
IB3 0 10 pwl(0 0 5p IB3)

LB1 3 1 1.712E-012
LB2 7 5 2.279E-012
LB3 10 8 2.858E-012

L1 a 1 2.062E-012
L2 1 4 2.06E-012
L3 5 4 2.079E-012
L4 5 q0 2.081E-012
L5 4 8 2.076E-012
L6 8 q1 2.086E-012

LP1 2 0 4.263E-013
LP2 6 0 3.75E-013
LP3 9 0 4.312E-013

RB1 1 101 RB1
LRB1 101 0 LRB1
RB2 5 105 RB2
LRB2 105 0 LRB2
RB3 8 108 RB3
LRB3 108 0 LRB3

.ends

Xc0 THmitll_SPLIT n_clk n_c0_q0 n_c0_q1
Xc1 THmitll_SPLIT n_c0_q0 n_c1_q0 n_c1_q1
Xc2 THmitll_SPLIT n_c0_q1 n_c2_q0 n_c2_q1
Xc3 THmitll_SPLIT n_c1_q0 n_c3_q0 n_c3_q1
Xc4 THmitll_SPLIT n_c1_q1 n_c4_q0 n_c4_q1
Xc5 THmitll_SPLIT n_c2_q0 n_c5_q0 n_c5_q1
Xc6 THmitll_SPLIT n_c2_q1 n_c6_q0 n_c6_q1
Xdff0 THmitll_DFF n_d n_c3_q0 n_dff0_q
Xdff1 THmitll_DFF n_dff0_q n_c3_q1 n_dff1_q
Xdff2 THmitll_DFF n_dff1_q n_c4_q0 n_dff2_q
Xdff3 THmitll_DFF n_dff2_q n_c4_q1 n_dff3_q
Xdff4 THmitll_DFF n_dff3_q n_c5_q0 n_dff4_q
Xdff5 THmitll_DFF n_dff4_q n_c5_q1 n_dff5_q
Xdff6 THmitll_DFF n_dff5_q n_c6_q0 n_dff6_q
Xdff7 THmitll_DFF n_dff6_q n_c6_q1 n_dff7_q

Xfxsrc_clk THmitll_DCSFQ n_fxsrc_clk_a n_clk
Ifxsrc_clk 0 n_fxsrc_clk_a pwl(0 0 220p 0 223p 600u 226p 0 420p 0 423p 600u 426p 0 620p 0 623p 600u 626p 0 820p 0 823p 600u 826p 0 1020p 0 1023p 600u 1026p 0 1220p 0 1223p 600u 1226p 0 1420p 0 1423p 600u 1426p 0 1620p 0 1623p 600u 1626p 0 1820p 0 1823p 600u 1826p 0 2020p 0 2023p 600u 2026p 0 2220p 0 2223p 600u 2226p 0 2420p 0 2423p 600u 2426p 0 2620p 0 2623p 600u 2626p 0 2820p 0 2823p 600u 2826p 0 3020p 0 3023p 600u 3026p 0 3220p 0 3223p 600u 3226p 0)
Xfxsrc_d THmitll_DCSFQ n_fxsrc_d_a n_d
Ifxsrc_d 0 n_fxsrc_d_a pwl(0 0 170p 0 173p 600u 176p 0 370p 0 373p 600u 376p 0 1170p 0 1173p 600u 1176p 0 1570p 0 1573p 600u 1576p 0 1770p 0 1773p 600u 1776p 0 2170p 0 2173p 600u 2176p 0 2770p 0 2773p 600u 2776p 0 2970p 0 2973p 600u 2976p 0 3170p 0 3173p 600u 3176p 0)

Xfxload_q THmitll_SFQDC n_dff7_q n_fxload_q_q
Rfxload_q n_fxload_q_q 0 2

.tran 0.025p 3720p 0
* fluxel-map c0.a P(B1|XC0)
* fluxel-map c0.q0 P(B2|XC0)
* fluxel-map c0.q1 P(B3|XC0)
* fluxel-map c1.a P(B1|XC1)
* fluxel-map c1.q0 P(B2|XC1)
* fluxel-map c1.q1 P(B3|XC1)
* fluxel-map c2.a P(B1|XC2)
* fluxel-map c2.q0 P(B2|XC2)
* fluxel-map c2.q1 P(B3|XC2)
* fluxel-map c3.a P(B1|XC3)
* fluxel-map c3.q0 P(B2|XC3)
* fluxel-map c3.q1 P(B3|XC3)
* fluxel-map c4.a P(B1|XC4)
* fluxel-map c4.q0 P(B2|XC4)
* fluxel-map c4.q1 P(B3|XC4)
* fluxel-map c5.a P(B1|XC5)
* fluxel-map c5.q0 P(B2|XC5)
* fluxel-map c5.q1 P(B3|XC5)
* fluxel-map c6.a P(B1|XC6)
* fluxel-map c6.q0 P(B2|XC6)
* fluxel-map c6.q1 P(B3|XC6)
* fluxel-map dff0.a P(B1|XDFF0)
* fluxel-map dff0.clk P(B5|XDFF0)
* fluxel-map dff0.q P(B7|XDFF0)
* fluxel-map dff1.a P(B1|XDFF1)
* fluxel-map dff1.clk P(B5|XDFF1)
* fluxel-map dff1.q P(B7|XDFF1)
* fluxel-map dff2.a P(B1|XDFF2)
* fluxel-map dff2.clk P(B5|XDFF2)
* fluxel-map dff2.q P(B7|XDFF2)
* fluxel-map dff3.a P(B1|XDFF3)
* fluxel-map dff3.clk P(B5|XDFF3)
* fluxel-map dff3.q P(B7|XDFF3)
* fluxel-map dff4.a P(B1|XDFF4)
* fluxel-map dff4.clk P(B5|XDFF4)
* fluxel-map dff4.q P(B7|XDFF4)
* fluxel-map dff5.a P(B1|XDFF5)
* fluxel-map dff5.clk P(B5|XDFF5)
* fluxel-map dff5.q P(B7|XDFF5)
* fluxel-map dff6.a P(B1|XDFF6)
* fluxel-map dff6.clk P(B5|XDFF6)
* fluxel-map dff6.q P(B7|XDFF6)
* fluxel-map dff7.a P(B1|XDFF7)
* fluxel-map dff7.clk P(B5|XDFF7)
* fluxel-map dff7.q P(B7|XDFF7)
* fluxel-map fxload_q.a P(B1|XFXLOAD_Q)
* fluxel-map fxload_q.q P(B8|XFXLOAD_Q)
* fluxel-map fxsrc_clk.a P(B1|XFXSRC_CLK)
* fluxel-map fxsrc_clk.q P(B3|XFXSRC_CLK)
* fluxel-map fxsrc_d.a P(B1|XFXSRC_D)
* fluxel-map fxsrc_d.q P(B3|XFXSRC_D)
.print p(B1.Xc0) p(B2.Xc0) p(B3.Xc0) p(B1.Xc1) p(B2.Xc1) p(B3.Xc1) p(B1.Xc2) p(B2.Xc2) p(B3.Xc2) p(B1.Xc3) p(B2.Xc3) p(B3.Xc3) p(B1.Xc4) p(B2.Xc4) p(B3.Xc4) p(B1.Xc5) p(B2.Xc5) p(B3.Xc5) p(B1.Xc6) p(B2.Xc6) p(B3.Xc6) p(B1.Xdff0) p(B5.Xdff0) p(B7.Xdff0) p(B1.Xdff1) p(B5.Xdff1) p(B7.Xdff1) p(B1.Xdff2) p(B5.Xdff2) p(B7.Xdff2) p(B1.Xdff3) p(B5.Xdff3) p(B7.Xdff3) p(B1.Xdff4) p(B5.Xdff4) p(B7.Xdff4) p(B1.Xdff5) p(B5.Xdff5) p(B7.Xdff5) p(B1.Xdff6) p(B5.Xdff6) p(B7.Xdff6) p(B1.Xdff7) p(B5.Xdff7) p(B7.Xdff7) p(B1.Xfxload_q) p(B8.Xfxload_q) p(B1.Xfxsrc_clk) p(B3.Xfxsrc_clk) p(B1.Xfxsrc_d) p(B3.Xfxsrc_d)
.end
